* Reusable one-stage SKY130 CTLE with source degeneration
.subckt CTLE inp inn outp outn vdd vss
+ params: RLOAD=1k RDEG=1k CDEG=0.5p ITAIL_VAL=100u MOS_W=10 MOS_L=0.15 MOS_M=1

RDP vdd outp {RLOAD}
RDN vdd outn {RLOAD}

* XMP/XMN intentionally share MOS_W/MOS_L/MOS_M: the differential pair is a matched sizing group.
XMP outp inp srcp vss sky130_fd_pr__nfet_01v8 W={MOS_W} L={MOS_L} m={MOS_M}
XMN outn inn srcn vss sky130_fd_pr__nfet_01v8 W={MOS_W} L={MOS_L} m={MOS_M}

RS1 srcp tail {RDEG}
RS2 srcn tail {RDEG}
CD1 srcp tail {CDEG}
CD2 srcn tail {CDEG}

ITAIL tail vss DC {ITAIL_VAL}
.ends CTLE
