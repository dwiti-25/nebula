* Nebula CTLE full AC-response bench
.lib "@@SKY130_MODEL_LIBRARY@@" @@PROCESS_CORNER@@
.include "@@CTLE_BLOCK_FILE@@"

.param RLOAD=1k RDEG=1k CDEG=0.5p ITAIL_VAL=100u
.param VDD_VAL=1.8 VIN_CM=1.2 CLOAD=20f
.temp @@TEMPERATURE_C@@

VDD vdd 0 {VDD_VAL}
VINP inp 0 DC {VIN_CM} AC 0.5
VINN inn 0 DC {VIN_CM} AC -0.5
CLOADP outp 0 {CLOAD}
CLOADN outn 0 {CLOAD}
XCTLE inp inn outp outn vdd 0 CTLE
+ RLOAD={RLOAD} RDEG={RDEG} CDEG={CDEG} ITAIL_VAL={ITAIL_VAL}

.control
set noaskquit
set wr_singlescale
set wr_vecnames
option numdgt=15
ac dec 100 1Meg 20Gig
let vin_diff = v(inp)-v(inn)
* The common-source pair inverts; use logical receiver polarity here.
let vout_diff = v(outn)-v(outp)
let transfer = vout_diff/vin_diff
let transfer_mag = mag(transfer)
let transfer_phase_deg = ph(transfer)
let vin_mag = mag(vin_diff)
let vout_mag = mag(vout_diff)
wrdata @@AC_OUTPUT_FILE@@ transfer_mag transfer_phase_deg vin_mag vout_mag
quit
.endc
.end
