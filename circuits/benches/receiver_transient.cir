* Nebula channel-driven CTLE transient bench
.lib "@@SKY130_MODEL_LIBRARY@@" @@PROCESS_CORNER@@
.include "@@CTLE_BLOCK_FILE@@"
.include "@@STIMULUS_INCLUDE_FILE@@"

.param RLOAD=1k RDEG=1k CDEG=0.5p ITAIL_VAL=100u
.param VDD_VAL=1.8 VIN_CM=1.2 CLOAD=20f CIN=0 SOURCE_LEG_R=50 RTERM_DIFF=100
.temp @@TEMPERATURE_C@@

VDD vdd 0 {VDD_VAL}
RCHP chp_src inp {SOURCE_LEG_R}
RCHN chn_src inn {SOURCE_LEG_R}
RTERM inp inn {RTERM_DIFF}
CINP inp 0 {CIN}
CINN inn 0 {CIN}
CLOADP outp 0 {CLOAD}
CLOADN outn 0 {CLOAD}
XCTLE inp inn outp outn vdd 0 CTLE
+ RLOAD={RLOAD} RDEG={RDEG} CDEG={CDEG} ITAIL_VAL={ITAIL_VAL}

.control
set noaskquit
set wr_singlescale
set wr_vecnames
option numdgt=15
tran @@TRANSIENT_STEP@@ @@TRANSIENT_END@@ 0 @@TRANSIENT_STEP@@
let vin_diff = v(inp)-v(inn)
let vout_diff = v(outn)-v(outp)
let supply_current = i(VDD)
wrdata @@WAVEFORM_OUTPUT_FILE@@ vin_diff vout_diff v(outp) v(outn) supply_current
quit
.endc
.end
