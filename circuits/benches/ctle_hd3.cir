* Nebula CTLE 100 MHz HD3 bench
.lib "@@SKY130_MODEL_LIBRARY@@" @@PROCESS_CORNER@@
.include "@@CTLE_BLOCK_FILE@@"

.param RLOAD=1k RDEG=1k CDEG=0.5p ITAIL_VAL=100u
.param VDD_VAL=1.8 VIN_CM=1.2 CLOAD=20f HD3_DIFF_PP=100m
.temp @@TEMPERATURE_C@@

VDD vdd 0 {VDD_VAL}
VINP inp 0 SIN({VIN_CM} {HD3_DIFF_PP/4} 100Meg)
VINN inn 0 SIN({VIN_CM} {HD3_DIFF_PP/4} 100Meg 0 0 180)
CLOADP outp 0 {CLOAD}
CLOADN outn 0 {CLOAD}
XCTLE inp inn outp outn vdd 0 CTLE
+ RLOAD={RLOAD} RDEG={RDEG} CDEG={CDEG} ITAIL_VAL={ITAIL_VAL}

.control
set noaskquit
set wr_singlescale
set wr_vecnames
option numdgt=15
tran 20p 500n 0 20p
let vout_diff = v(outn)-v(outp)
wrdata @@HD3_OUTPUT_FILE@@ vout_diff
quit
.endc
.end
