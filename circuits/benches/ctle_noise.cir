* Nebula CTLE differential input-referred noise bench
.lib "@@SKY130_MODEL_LIBRARY@@" @@PROCESS_CORNER@@
.include "@@CTLE_BLOCK_FILE@@"

.param RLOAD=1k RDEG=1k CDEG=0.5p ITAIL_VAL=100u
.param VDD_VAL=1.8 VIN_CM=1.2 CLOAD=20f RBIAS=1g
.temp @@TEMPERATURE_C@@

VDD vdd 0 {VDD_VAL}
VCM cm 0 {VIN_CM}
RBIASP inp cm {RBIAS}
RBIASN inn cm {RBIAS}
VTEST inp inn DC 0 AC 1
CLOADP outp 0 {CLOAD}
CLOADN outn 0 {CLOAD}
XCTLE inp inn outp outn vdd 0 CTLE
+ RLOAD={RLOAD} RDEG={RDEG} CDEG={CDEG} ITAIL_VAL={ITAIL_VAL}

.control
set noaskquit
set wr_singlescale
set wr_vecnames
option numdgt=15
* The common-source pair inverts; output ordering follows logical data polarity.
noise v(outn,outp) VTEST dec 100 10Meg 5Gig
setplot noise1
wrdata @@NOISE_OUTPUT_FILE@@ inoise_spectrum onoise_spectrum
quit
.endc
.end
