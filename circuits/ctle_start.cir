* SKY130 CTLE - parameterized baseline

.lib /Users/dwitisuchak/.ciel/sky130A/libs.tech/ngspice/sky130.lib.spice tt

* Tunable parameters
.param RLOAD=1k
.param RDEG=1k
.param CDEG=0.5p
.param ITAIL_VAL=100u

VDD vdd 0 1.8

* Differential input
VINP inp 0 DC 1.2 AC 0.5
VINN inn 0 DC 1.2 AC -0.5

* Resistive loads
RDP vdd outp {RLOAD}
RDN vdd outn {RLOAD}

* NMOS differential pair
* Keep W/L fixed for now
XMP outp inp srcp 0 sky130_fd_pr__nfet_01v8 W=10 L=0.15
XMN outn inn srcn 0 sky130_fd_pr__nfet_01v8 W=10 L=0.15

* Source degeneration
RS1 srcp tail {RDEG}
RS2 srcn tail {RDEG}

* Degeneration capacitors
CD1 srcp tail {CDEG}
CD2 srcn tail {CDEG}

* Tail current
ITAIL tail 0 DC {ITAIL_VAL}

.op

.ac dec 100 1Meg 100Gig

.print ac vdb(outp,outn)

.end
